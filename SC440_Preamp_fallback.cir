* SC440 OPA1678 daughterboard - transient fallback netlist
* Hardware gain: 1 + 22k/10k = 3.2 (+10.10 dB)
.include vendor/OPA167x_ngspice.LIB
VCC vcc 0 DC 5
R6 vcc vcc_a 22
C4 vcc_a 0 10u
C5 vcc_a 0 100n
R1 vcc_a vref_raw 10k
R2 vref_raw 0 10k
C2 vref_raw 0 47u
C3 vref_raw 0 100n
* OPA167x pin order: IN+ IN- VCC VEE OUT
XREF vref_raw vref vcc_a 0 vref OPA167x
* Measured SC440 source-follower output: 2.426 V DC + 10 mVpk @ 1 kHz
VIN analog_input 0 DC 2.426 AC 1 SIN(2.426 10m 1k)
* Default input coupling: C6 1 uF MLCC. C1 film option is DNP.
C6 analog_input in_ac 1u
R3 in_ac vref 100k
XAMP in_ac fb vcc_a 0 preamp_out OPA167x
R5 preamp_out fb 22k
R4 fb vref 10k
R7 preamp_out analog_output 100
RLOAD analog_output 0 1Meg
.tran 10u 20m 0 10u
.end
