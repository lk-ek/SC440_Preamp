SC440 preamp AC reference
.include vendor/OPA1678_AC_ngspice.lib
VCC +5V 0 5
R6 +5V VCC_A 22
C4 VCC_A 0 10u
C5 VCC_A 0 100n
R1 VCC_A VREF_RAW 10k
R2 VREF_RAW 0 10k
C2 VREF_RAW 0 47u
C3 VREF_RAW 0 100n
XREF VREF_RAW VREF VCC_A 0 VREF OPA1678_AC
VIN ANALOG_INPUT 0 DC 2.426 AC 1
C6 ANALOG_INPUT IN_AC 1u
R3 IN_AC VREF 100k
XAMP IN_AC FB VCC_A 0 PREAMP_OUT OPA1678_AC
R5 PREAMP_OUT FB 22k
R4 FB VREF 10k
R7 PREAMP_OUT ANALOG_OUTPUT 100
.ac dec 100 0.1 10Meg
.end
